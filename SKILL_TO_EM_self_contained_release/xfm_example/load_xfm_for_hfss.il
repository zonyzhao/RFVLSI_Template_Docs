load("vias.il")
load("vias_diagonal.il")
load("base_ind_under.il")
load("base_ind_diag.il")
load("base_xfm_lead.il")
load("base_xfm_lead_pair.il")
load("base_balun_half.il")
load("base_balun_halfud.il")
load("base_xfm_cross.il")
load("base_xfm_highk_pri.il")
load("base_xfm_dmy.il")
load("base_xfm_body.il")
load("base_xfm_half.il")
load("base_xfm_halfud.il")
load("base_balun_sec.il")
load("xfm_highk.il")
load("xfm_highk_ct.il")
load("vias_port_test.il")
load("base_MOS_GATE_LINK_esub.il")
load("base_MOS_vias_min.il")
