load("vias.il")
load("vias_diagonal.il")
load("vias_dmexcl.il")
load("mesh_rect.il")
load("mesh_rect_asym.il")
load("mesh_diagonal.il")
load("base_oct.il")
load("base_oct_half.il")
load("base_oct_half_fill.il")
load("base_oct_quad.il")
load("base_oct_quad_fill.il")
load("base_xfm_cross.il")
load("base_ind_diag.il")
load("X.il")
load("base_lead.il")
load("base_lead_pair.il")
load("base_under.il")
load("base_oct_fill.il")
load("base_pri_chu.il")
load("RF_PAD_QUART.il")
load("base_cpwtline_halfs.il")
load("base_admexcl.il")
load("cpw_diff.il")
load("base_path_bend.il")
load("mesh_tri.il")
load("cpwtline45s.il")
load("xfm_highk_rx_chu.il")
load("xfm_highk_rx_ct_chu.il")
;load("rf_pad.il")
;load("rfgnd_pad.il")
;load("path_analog_stacked.il")
load("Lo_buf.il)
