outmat = infile("/home/chatrpol/OA65/Ocean_scripts/out_mat.txt")
fscanf(outmat "%s %f \n" var1name var1)
fscanf(outmat "%s %f \n" var2name var2)
fscanf(outmat "%s %f \n" var3name var3)
fscanf(outmat "%s %f \n" var4name var4)
fscanf(outmat "%s %f \n" var5name var5)

printf( "%s %n \n"  var1name var1)
printf( "%s %n \n"  var2name var2)
printf( "%s %n \n"  var3name var3)
printf( "%s %n \n"  var4name var4)
printf( "%s %n \n"  var5name var5)

if(var1name=="Wmin" then Wmx=var1)
if(var2name=="fgin" then fgx=var2)
if(var3name=="viin" then vix=var3)
if(var4name=="Witvin" then Witvx=var4)
if(var5name=="fgitvin" then fgitvx=var5)
;if(var6name=="Ritcin" then Ritcx=var6)

printf( "Wm %n \n"  Wmx)
printf( "fg %n \n"  fgx)
printf( "vi %n \n"  vix)
printf( "Witv %n \n"  Witvx)
printf( "fgitv %n \n"  fgitvx)
;printf( "Ritc %n \n"  Ritcx)

simulator( 'spectre )
design(	 "/home/chatrpol/simulation/Mos_sixstage_HW_vtc2/spectre/NchPch25/netlist/netlist")
resultsDir( "/home/chatrpol/simulation/Mos_sixstage_HW_vtc2/spectre/NchPch25" )
modelFile(
    '("/home/PDKs/OA65_LIB/tsmcN65/../models/spectre/crn65gplus_2d5_lk_v1d0.scs" "tt_bip")
    '("/home/PDKs/OA65_LIB/tsmcN65/../models/spectre/crn65gplus_2d5_lk_v1d0.scs" "tt_dio")
    '("/home/PDKs/OA65_LIB/tsmcN65/../models/spectre/crn65gplus_2d5_lk_v1d0.scs" "tt_dio_33")
    '("/home/PDKs/OA65_LIB/tsmcN65/../models/spectre/crn65gplus_2d5_lk_v1d0.scs" "tt_mim")
    '("/home/PDKs/OA65_LIB/tsmcN65/../models/spectre/crn65gplus_2d5_lk_v1d0.scs" "tt_dio_dnw")
    '("/home/PDKs/OA65_LIB/tsmcN65/../models/spectre/crn65gplus_2d5_lk_v1d0.scs" "tt_dio_18")
    '("/home/PDKs/OA65_LIB/tsmcN65/../models/spectre/crn65gplus_2d5_lk_v1d0.scs" "tt_bip_npn")
    '("/home/PDKs/OA65_LIB/tsmcN65/../models/spectre/crn65gplus_2d5_lk_v1d0.scs" "tt_33")
    '("/home/PDKs/OA65_LIB/tsmcN65/../models/spectre/crn65gplus_2d5_lk_v1d0.scs" "tt_rfrtmom")
    '("/home/PDKs/OA65_LIB/tsmcN65/../models/spectre/crn65gplus_2d5_lk_v1d0.scs" "tt_mos_cap_25")
    '("/home/PDKs/OA65_LIB/tsmcN65/../models/spectre/crn65gplus_2d5_lk_v1d0.scs" "tt_18")
    '("/home/PDKs/OA65_LIB/tsmcN65/../models/spectre/crn65gplus_2d5_lk_v1d0.scs" "tt_disres")
    '("/home/PDKs/OA65_LIB/tsmcN65/../models/spectre/crn65gplus_2d5_lk_v1d0.scs" "tt_res")
    '("/home/PDKs/OA65_LIB/tsmcN65/../models/spectre/crn65gplus_2d5_lk_v1d0.scs" "tt_dio_na")
    '("/home/PDKs/OA65_LIB/tsmcN65/../models/spectre/crn65gplus_2d5_lk_v1d0.scs" "tt_rfmos_33")
    '("/home/PDKs/OA65_LIB/tsmcN65/../models/spectre/crn65gplus_2d5_lk_v1d0.scs" "tt_dio_hvt")
    '("/home/PDKs/OA65_LIB/tsmcN65/../models/spectre/crn65gplus_2d5_lk_v1d0.scs" "tt_rfmvar")
    '("/home/PDKs/OA65_LIB/tsmcN65/../models/spectre/crn65gplus_2d5_lk_v1d0.scs" "tt_rfmos_18")
    '("/home/PDKs/OA65_LIB/tsmcN65/../models/spectre/crn65gplus_2d5_lk_v1d0.scs" "tt_na")
    '("/home/PDKs/OA65_LIB/tsmcN65/../models/spectre/crn65gplus_2d5_lk_v1d0.scs" "tt_dio_na33")
    '("/home/PDKs/OA65_LIB/tsmcN65/../models/spectre/crn65gplus_2d5_lk_v1d0.scs" "tt_dio_lvt")
    '("/home/PDKs/OA65_LIB/tsmcN65/../models/spectre/crn65gplus_2d5_lk_v1d0.scs" "tt_rfres_sa")
    '("/home/PDKs/OA65_LIB/tsmcN65/../models/spectre/crn65gplus_2d5_lk_v1d0.scs" "tt_na33")
    '("/home/PDKs/OA65_LIB/tsmcN65/../models/spectre/crn65gplus_2d5_lk_v1d0.scs" "tt_dio_esd")
    '("/home/PDKs/OA65_LIB/tsmcN65/../models/spectre/crn65gplus_2d5_lk_v1d0.scs" "tt_rfmim")
    '("/home/PDKs/OA65_LIB/tsmcN65/../models/spectre/crn65gplus_2d5_lk_v1d0.scs" "tt_dio_25od33")
    '("/home/PDKs/OA65_LIB/tsmcN65/../models/spectre/crn65gplus_2d5_lk_v1d0.scs" "tt_25od33")
    '("/home/PDKs/OA65_LIB/tsmcN65/../models/spectre/crn65gplus_2d5_lk_v1d0.scs" "tt")
    '("/home/PDKs/OA65_LIB/tsmcN65/../models/spectre/crn65gplus_2d5_lk_v1d0.scs" "tt_mos_cap")
    '("/home/PDKs/OA65_LIB/tsmcN65/../models/spectre/crn65gplus_2d5_lk_v1d0.scs" "tt_dio_25")
    '("/home/PDKs/OA65_LIB/tsmcN65/../models/spectre/crn65gplus_2d5_lk_v1d0.scs" "tt_dio_25ud18")
    '("/home/PDKs/OA65_LIB/tsmcN65/../models/spectre/crn65gplus_2d5_lk_v1d0.scs" "tt_25")
    '("/home/PDKs/OA65_LIB/tsmcN65/../models/spectre/crn65gplus_2d5_lk_v1d0.scs" "tt_rfmos")
    '("/home/PDKs/OA65_LIB/tsmcN65/../models/spectre/crn65gplus_2d5_lk_v1d0.scs" "tt_25ud18")
    '("/home/PDKs/OA65_LIB/tsmcN65/../models/spectre/crn65gplus_2d5_lk_v1d0.scs" "tt_dio_na25od33")
    '("/home/PDKs/OA65_LIB/tsmcN65/../models/spectre/crn65gplus_2d5_lk_v1d0.scs" "tt_rfjvar")
    '("/home/PDKs/OA65_LIB/tsmcN65/../models/spectre/crn65gplus_2d5_lk_v1d0.scs" "tt_rfmos_25")
    '("/home/PDKs/OA65_LIB/tsmcN65/../models/spectre/crn65gplus_2d5_lk_v1d0.scs" "tt_rtmom")
    '("/home/PDKs/OA65_LIB/tsmcN65/../models/spectre/crn65gplus_2d5_lk_v1d0.scs" "tt_na25od33")
    '("/home/PDKs/OA65_LIB/tsmcN65/../models/spectre/crn65gplus_2d5_lk_v1d0.scs" "tt_dio_na25")
    '("/home/PDKs/OA65_LIB/tsmcN65/../models/spectre/crn65gplus_2d5_lk_v1d0.scs" "tt_rfres_rpo")
    '("/home/PDKs/OA65_LIB/tsmcN65/../models/spectre/crn65gplus_2d5_lk_v1d0.scs" "tt_hvt")
    '("/home/PDKs/OA65_LIB/tsmcN65/../models/spectre/crn65gplus_2d5_lk_v1d0.scs" "tt_rfind")
    '("/home/PDKs/OA65_LIB/tsmcN65/../models/spectre/crn65gplus_2d5_lk_v1d0.scs" "tt_rfmvar_25")
    '("/home/PDKs/OA65_LIB/tsmcN65/../models/spectre/crn65gplus_2d5_lk_v1d0.scs" "tt_na25")
    '("/home/PDKs/OA65_LIB/tsmcN65/../models/spectre/crn65gplus_2d5_lk_v1d0.scs" "tt_lvt")
)
analysis('pss ?engine "Harmonic Balance"  ?flexbalance "yes"  ?oversamplefactor ""
		?fund "950M"  ?harms "3"  ?errpreset "conservative"  ?step ""
		?write ""  ?writefinal ""  ?swapfile ""  ?checkpss ""
		?backtracking ""  )
desVar(	  "ci" 40p	)
desVar(	  "citv" 5p	)
desVar(	  "vi" 0.8	)
desVar(	  "Ritc" 40K	)
desVar(	  "fg" fgx	)
desVar(	  "Lm" 60n	)
desVar(	  "wb" Witvx )
desVar(	  "Wm" Wmx	)
desVar(	  "fgitv" fgitvx	)
desVar(	  "Voutrf" vix	)
envOption(
	'autoDisplay  nil
	'analysisOrder  list("pss" "tran")
)
save( 'i "/Idd/PLUS" "/Irf/PLUS" )
temp( 27 )
run()
Pout_pss = real((harmonic(v("/vdd" ?result "pss-fd.pss") 0) * harmonic(i("/Idd/PLUS" ?result "pss-fd.pss") 0)))
printf( "Pout_pss %10.10f \n"  Pout_pss)
Pin_pss = real(((harmonic(v("/Vinrf" ?result "pss-fd.pss") 1) * conjugate(harmonic(i("/Irf/PLUS" ?result "pss-fd.pss") 1)) * 1) / 2))
printf( "Pin_pss %10.10f \n"  Pin_pss)
Pratio_pss = (Pout_pss / Pin_pss)
printf( "Pratio_pss %10.10f \n"  Pratio_pss)
Idcout_pss = real(harmonic(i("/Idd/PLUS" ?result "pss-fd.pss") 0))
printf( "Idcout_pss %10.10f \n"  Idcout_pss)
Rdcout_pss = (real(harmonic(v("/vdd" ?result "pss-fd.pss") 0)) / real(harmonic(i("/Idd/PLUS" ?result "pss-fd.pss") 0)))
printf( "Rdcout_pss %10.10f \n"  Rdcout_pss)

outpss = outfile("/home/chatrpol/OA65/Ocean_scripts/out_pss.txt")
 fprintf(outpss "%10.10f %10.10f %10.10f %10.10f %10.10f"
		Pout_pss Pin_pss Pratio_pss Idcout_pss Rdcout_pss)

close(outpss)
close(outmat)
exit
