;;;;; Begin ;;;;;
InputFile = infile("/home/childish/OA65/Ocean_Scripts/tb_xfm2p_1to1_OD90/schematic_Fit_InputVar.txt")
fscanf(InputFile "%s %f \n" var1name var1)
fscanf(InputFile "%s %f \n" var2name var2)
fscanf(InputFile "%s %f \n" var3name var3)
fscanf(InputFile "%s %f \n" var4name var4)
fscanf(InputFile "%s %f \n" var5name var5)
fscanf(InputFile "%s %f \n" var6name var6)
fscanf(InputFile "%s %f \n" var7name var7)
fscanf(InputFile "%s %f \n" var8name var8)
fscanf(InputFile "%s %f \n" var9name var9)
fscanf(InputFile "%s %f \n" var10name var10)
fscanf(InputFile "%s %f \n" var11name var11)
fscanf(InputFile "%s %f \n" var12name var12)
fscanf(InputFile "%s %f \n" var13name var13)
fscanf(InputFile "%s %f \n" var14name var14)
fscanf(InputFile "%s %f \n" var15name var15)
fscanf(InputFile "%s %f \n" var16name var16)
fscanf(InputFile "%s %f \n" var17name var17)
fscanf(InputFile "%s %f \n" var18name var18)
fscanf(InputFile "%s %f \n" var19name var19)
fscanf(InputFile "%s %f \n" var20name var20)
fscanf(InputFile "%s %f \n" var21name var21)
fscanf(InputFile "%s %f \n" var22name var22)
fscanf(InputFile "%s %f \n" var23name var23)
fscanf(InputFile "%s %f \n" var24name var24)
fscanf(InputFile "%s %f \n" var25name var25)
fscanf(InputFile "%s %f \n" var26name var26)
fscanf(InputFile "%s %f \n" var27name var27)
if(var1name=="C12" then C12_x=var1)
if(var2name=="C13" then C13_x=var2)
if(var3name=="C14" then C14_x=var3)
if(var4name=="C24" then C24_x=var4)
if(var5name=="C32" then C32_x=var5)
if(var6name=="C34" then C34_x=var6)
if(var7name=="Cs1" then Cs1_x=var7)
if(var8name=="Cs2" then Cs2_x=var8)
if(var9name=="Cs3" then Cs3_x=var9)
if(var10name=="Cs4" then Cs4_x=var10)
if(var11name=="Cs5" then Cs5_x=var11)
if(var12name=="Cs6" then Cs6_x=var12)
if(var13name=="Cs7" then Cs7_x=var13)
if(var14name=="Cs8" then Cs8_x=var14)
if(var15name=="k" then k_x=var15)
if(var16name=="L1" then L1_x=var16)
if(var17name=="L2" then L2_x=var17)
if(var18name=="L3" then L3_x=var18)
if(var19name=="L4" then L4_x=var19)
if(var20name=="R1" then R1_x=var20)
if(var21name=="R2" then R2_x=var21)
if(var22name=="R3" then R3_x=var22)
if(var23name=="R4" then R4_x=var23)
if(var24name=="Rs5" then Rs5_x=var24)
if(var25name=="Rs6" then Rs6_x=var25)
if(var26name=="Rs7" then Rs7_x=var26)
if(var27name=="Rs8" then Rs8_x=var27)
;;;;; End ;;;;;

simulator( 'spectre )
design(	 "/home/childish/simulation/tb_xfm2p_1to1_OD90/spectre/schematic_Fit/netlist/netlist")
resultsDir( "/home/childish/simulation/tb_xfm2p_1to1_OD90/spectre/schematic_Fit" )
;modelFile(
;    '("/home/PDKs/OA65_LIB/tsmcN65/../models/spectre/crn65gplus_2d5_lk_v1d0.scs" "tt_bip")
;    '("/home/PDKs/OA65_LIB/tsmcN65/../models/spectre/crn65gplus_2d5_lk_v1d0.scs" "tt_dio")
;    '("/home/PDKs/OA65_LIB/tsmcN65/../models/spectre/crn65gplus_2d5_lk_v1d0.scs" "tt_dio_33")
;    '("/home/PDKs/OA65_LIB/tsmcN65/../models/spectre/crn65gplus_2d5_lk_v1d0.scs" "tt_mim")
;    '("/home/PDKs/OA65_LIB/tsmcN65/../models/spectre/crn65gplus_2d5_lk_v1d0.scs" "tt_dio_dnw")
;    '("/home/PDKs/OA65_LIB/tsmcN65/../models/spectre/crn65gplus_2d5_lk_v1d0.scs" "tt_dio_18")
;    '("/home/PDKs/OA65_LIB/tsmcN65/../models/spectre/crn65gplus_2d5_lk_v1d0.scs" "tt_bip_npn")
;    '("/home/PDKs/OA65_LIB/tsmcN65/../models/spectre/crn65gplus_2d5_lk_v1d0.scs" "tt_33")
;    '("/home/PDKs/OA65_LIB/tsmcN65/../models/spectre/crn65gplus_2d5_lk_v1d0.scs" "tt_rfrtmom")
;    '("/home/PDKs/OA65_LIB/tsmcN65/../models/spectre/crn65gplus_2d5_lk_v1d0.scs" "tt_mos_cap_25")
;    '("/home/PDKs/OA65_LIB/tsmcN65/../models/spectre/crn65gplus_2d5_lk_v1d0.scs" "tt_18")
;    '("/home/PDKs/OA65_LIB/tsmcN65/../models/spectre/crn65gplus_2d5_lk_v1d0.scs" "tt_disres")
;   '("/home/PDKs/OA65_LIB/tsmcN65/../models/spectre/crn65gplus_2d5_lk_v1d0.scs" "tt_res")
;   '("/home/PDKs/OA65_LIB/tsmcN65/../models/spectre/crn65gplus_2d5_lk_v1d0.scs" "tt_dio_na")
;   '("/home/PDKs/OA65_LIB/tsmcN65/../models/spectre/crn65gplus_2d5_lk_v1d0.scs" "tt_rfmos_33")
;   '("/home/PDKs/OA65_LIB/tsmcN65/../models/spectre/crn65gplus_2d5_lk_v1d0.scs" "tt_dio_hvt")
;   '("/home/PDKs/OA65_LIB/tsmcN65/../models/spectre/crn65gplus_2d5_lk_v1d0.scs" "tt_rfmvar")
;   '("/home/PDKs/OA65_LIB/tsmcN65/../models/spectre/crn65gplus_2d5_lk_v1d0.scs" "tt_rfmos_18")
;   '("/home/PDKs/OA65_LIB/tsmcN65/../models/spectre/crn65gplus_2d5_lk_v1d0.scs" "tt_na")
;   '("/home/PDKs/OA65_LIB/tsmcN65/../models/spectre/crn65gplus_2d5_lk_v1d0.scs" "tt_dio_na33")
;   '("/home/PDKs/OA65_LIB/tsmcN65/../models/spectre/crn65gplus_2d5_lk_v1d0.scs" "tt_dio_lvt")
;   '("/home/PDKs/OA65_LIB/tsmcN65/../models/spectre/crn65gplus_2d5_lk_v1d0.scs" "tt_rfres_sa")
;   '("/home/PDKs/OA65_LIB/tsmcN65/../models/spectre/crn65gplus_2d5_lk_v1d0.scs" "tt_na33")
;   '("/home/PDKs/OA65_LIB/tsmcN65/../models/spectre/crn65gplus_2d5_lk_v1d0.scs" "tt_dio_esd")
;    '("/home/PDKs/OA65_LIB/tsmcN65/../models/spectre/crn65gplus_2d5_lk_v1d0.scs" "tt_rfmim")
;    '("/home/PDKs/OA65_LIB/tsmcN65/../models/spectre/crn65gplus_2d5_lk_v1d0.scs" "tt_dio_25od33")
;    '("/home/PDKs/OA65_LIB/tsmcN65/../models/spectre/crn65gplus_2d5_lk_v1d0.scs" "tt_25od33")
;    '("/home/PDKs/OA65_LIB/tsmcN65/../models/spectre/crn65gplus_2d5_lk_v1d0.scs" "tt")
;    '("/home/PDKs/OA65_LIB/tsmcN65/../models/spectre/crn65gplus_2d5_lk_v1d0.scs" "tt_mos_cap")
;    '("/home/PDKs/OA65_LIB/tsmcN65/../models/spectre/crn65gplus_2d5_lk_v1d0.scs" "tt_dio_25")
;    '("/home/PDKs/OA65_LIB/tsmcN65/../models/spectre/crn65gplus_2d5_lk_v1d0.scs" "tt_dio_25ud18")
;    '("/home/PDKs/OA65_LIB/tsmcN65/../models/spectre/crn65gplus_2d5_lk_v1d0.scs" "tt_25")
;    '("/home/PDKs/OA65_LIB/tsmcN65/../models/spectre/crn65gplus_2d5_lk_v1d0.scs" "tt_rfmos")
;    '("/home/PDKs/OA65_LIB/tsmcN65/../models/spectre/crn65gplus_2d5_lk_v1d0.scs" "tt_25ud18")
;    '("/home/PDKs/OA65_LIB/tsmcN65/../models/spectre/crn65gplus_2d5_lk_v1d0.scs" "tt_dio_na25od33")
;    '("/home/PDKs/OA65_LIB/tsmcN65/../models/spectre/crn65gplus_2d5_lk_v1d0.scs" "tt_rfjvar")
;    '("/home/PDKs/OA65_LIB/tsmcN65/../models/spectre/crn65gplus_2d5_lk_v1d0.scs" "tt_rfmos_25")
;    '("/home/PDKs/OA65_LIB/tsmcN65/../models/spectre/crn65gplus_2d5_lk_v1d0.scs" "tt_rtmom")
;    '("/home/PDKs/OA65_LIB/tsmcN65/../models/spectre/crn65gplus_2d5_lk_v1d0.scs" "tt_na25od33")
;    '("/home/PDKs/OA65_LIB/tsmcN65/../models/spectre/crn65gplus_2d5_lk_v1d0.scs" "tt_dio_na25")
;    '("/home/PDKs/OA65_LIB/tsmcN65/../models/spectre/crn65gplus_2d5_lk_v1d0.scs" "tt_rfres_rpo")
;    '("/home/PDKs/OA65_LIB/tsmcN65/../models/spectre/crn65gplus_2d5_lk_v1d0.scs" "tt_hvt")
;    '("/home/PDKs/OA65_LIB/tsmcN65/../models/spectre/crn65gplus_2d5_lk_v1d0.scs" "tt_rfind")
;    '("/home/PDKs/OA65_LIB/tsmcN65/../models/spectre/crn65gplus_2d5_lk_v1d0.scs" "tt_rfmvar_25")
;    '("/home/PDKs/OA65_LIB/tsmcN65/../models/spectre/crn65gplus_2d5_lk_v1d0.scs" "tt_na25")
;    '("/home/PDKs/OA65_LIB/tsmcN65/../models/spectre/crn65gplus_2d5_lk_v1d0.scs" "tt_lvt")
;)
analysis('sp ?ports list("/PORT1" "/PORT2")  ?start "1G"  ?stop "120G"
		?step "0.5G"  ?values list("60G")  )
desVar(	  "C12" C12_x	)
desVar(	  "C13" C13_x	)
desVar(	  "C14" C14_x	)
desVar(	  "C24" C24_x	)
desVar(	  "C32" C32_x	)
desVar(	  "C34" C34_x	)
desVar(	  "Cs1" Cs1_x	)
desVar(	  "Cs2" Cs2_x	)
desVar(	  "Cs3" Cs3_x	)
desVar(	  "Cs4" Cs4_x	)
desVar(	  "Cs5" Cs5_x	)
desVar(	  "Cs6" Cs6_x	)
desVar(	  "Cs7" Cs7_x	)
desVar(	  "Cs8" Cs8_x	)
desVar(	  "k" k_x	)
desVar(	  "L1" L1_x	)
desVar(	  "L2" L2_x	)
desVar(	  "L3" L3_x	)
desVar(	  "L4" L4_x	)
desVar(	  "R1" R1_x	)
desVar(	  "R2" R2_x	)
desVar(	  "R3" R3_x	)
desVar(	  "R4" R4_x	)
desVar(	  "Rs5" Rs5_x	)
desVar(	  "Rs6" Rs6_x	)
desVar(	  "Rs7" Rs7_x	)
desVar(	  "Rs8" Rs8_x	)
envOption(
	'analysisOrder  list("sp")
)
temp( 27 )
run()

;;;;; Begin ;;;;;
printf("Begin   \n")
results()
selectResult( 'sp )
s11 = sp(1 1)
s12 = sp(1 2)
s21 = sp(2 1)
s22 = sp(2 2)

printf("Writing Files ...    \n")
OutputFile = outfile("/home/childish/OA65/Ocean_Scripts/tb_xfm2p_1to1_OD90/schematic_Fit_sp.txt" "w")
ocnPrint(?output OutputFile ?numberNotation 'none s11 s12 s21 s22)
close(OutputFile)
printf("End")
exit	; Terminate Spectre Operation
;;;;; End ;;;;;
