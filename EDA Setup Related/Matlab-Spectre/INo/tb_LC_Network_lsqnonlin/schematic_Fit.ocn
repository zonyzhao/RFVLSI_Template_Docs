;;;;; Begin ;;;;;
InputFile = infile("/home/childish/OA65/Ocean_Scripts/tb_LC_Network_lsqnonlin/schematic_Fit_InputVar.txt")
fscanf(InputFile "%s %f \n" var1name var1)
fscanf(InputFile "%s %f \n" var2name var2)
if(var1name=="L" then L_x=var1)
if(var2name=="C" then C_x=var2)
;;;;; End ;;;;;

simulator( 'spectre )
design(	 "/home/childish/simulation/tb_LC_Network/spectre/schematic_Fit/netlist/netlist")
resultsDir( "/home/childish/simulation/tb_LC_Network/spectre/schematic_Fit" )
;modelFile(
;    '("/home/PDKs/OA65_LIB/tsmcN65/../models/spectre/crn65gplus_2d5_lk_v1d0.scs" "tt_bip")
;    '("/home/PDKs/OA65_LIB/tsmcN65/../models/spectre/crn65gplus_2d5_lk_v1d0.scs" "tt_dio")
;    '("/home/PDKs/OA65_LIB/tsmcN65/../models/spectre/crn65gplus_2d5_lk_v1d0.scs" "tt_dio_33")
;    '("/home/PDKs/OA65_LIB/tsmcN65/../models/spectre/crn65gplus_2d5_lk_v1d0.scs" "tt_mim")
;    '("/home/PDKs/OA65_LIB/tsmcN65/../models/spectre/crn65gplus_2d5_lk_v1d0.scs" "tt_dio_dnw")
;    '("/home/PDKs/OA65_LIB/tsmcN65/../models/spectre/crn65gplus_2d5_lk_v1d0.scs" "tt_dio_18")
;    '("/home/PDKs/OA65_LIB/tsmcN65/../models/spectre/crn65gplus_2d5_lk_v1d0.scs" "tt_bip_npn")
;    '("/home/PDKs/OA65_LIB/tsmcN65/../models/spectre/crn65gplus_2d5_lk_v1d0.scs" "tt_33")
;    '("/home/PDKs/OA65_LIB/tsmcN65/../models/spectre/crn65gplus_2d5_lk_v1d0.scs" "tt_rfrtmom")
;    '("/home/PDKs/OA65_LIB/tsmcN65/../models/spectre/crn65gplus_2d5_lk_v1d0.scs" "tt_mos_cap_25")
;    '("/home/PDKs/OA65_LIB/tsmcN65/../models/spectre/crn65gplus_2d5_lk_v1d0.scs" "tt_18")
;    '("/home/PDKs/OA65_LIB/tsmcN65/../models/spectre/crn65gplus_2d5_lk_v1d0.scs" "tt_disres")
;    '("/home/PDKs/OA65_LIB/tsmcN65/../models/spectre/crn65gplus_2d5_lk_v1d0.scs" "tt_res")
;    '("/home/PDKs/OA65_LIB/tsmcN65/../models/spectre/crn65gplus_2d5_lk_v1d0.scs" "tt_dio_na")
;    '("/home/PDKs/OA65_LIB/tsmcN65/../models/spectre/crn65gplus_2d5_lk_v1d0.scs" "tt_rfmos_33")
;    '("/home/PDKs/OA65_LIB/tsmcN65/../models/spectre/crn65gplus_2d5_lk_v1d0.scs" "tt_dio_hvt")
;    '("/home/PDKs/OA65_LIB/tsmcN65/../models/spectre/crn65gplus_2d5_lk_v1d0.scs" "tt_rfmvar")
;    '("/home/PDKs/OA65_LIB/tsmcN65/../models/spectre/crn65gplus_2d5_lk_v1d0.scs" "tt_rfmos_18")
;    '("/home/PDKs/OA65_LIB/tsmcN65/../models/spectre/crn65gplus_2d5_lk_v1d0.scs" "tt_na")
;    '("/home/PDKs/OA65_LIB/tsmcN65/../models/spectre/crn65gplus_2d5_lk_v1d0.scs" "tt_dio_na33")
;    '("/home/PDKs/OA65_LIB/tsmcN65/../models/spectre/crn65gplus_2d5_lk_v1d0.scs" "tt_dio_lvt")
;    '("/home/PDKs/OA65_LIB/tsmcN65/../models/spectre/crn65gplus_2d5_lk_v1d0.scs" "tt_rfres_sa")
;    '("/home/PDKs/OA65_LIB/tsmcN65/../models/spectre/crn65gplus_2d5_lk_v1d0.scs" "tt_na33")
;    '("/home/PDKs/OA65_LIB/tsmcN65/../models/spectre/crn65gplus_2d5_lk_v1d0.scs" "tt_dio_esd")
;    '("/home/PDKs/OA65_LIB/tsmcN65/../models/spectre/crn65gplus_2d5_lk_v1d0.scs" "tt_rfmim")
;    '("/home/PDKs/OA65_LIB/tsmcN65/../models/spectre/crn65gplus_2d5_lk_v1d0.scs" "tt_dio_25od33")
;    '("/home/PDKs/OA65_LIB/tsmcN65/../models/spectre/crn65gplus_2d5_lk_v1d0.scs" "tt_25od33")
;    '("/home/PDKs/OA65_LIB/tsmcN65/../models/spectre/crn65gplus_2d5_lk_v1d0.scs" "tt")
;    '("/home/PDKs/OA65_LIB/tsmcN65/../models/spectre/crn65gplus_2d5_lk_v1d0.scs" "tt_mos_cap")
;    '("/home/PDKs/OA65_LIB/tsmcN65/../models/spectre/crn65gplus_2d5_lk_v1d0.scs" "tt_dio_25")
;    '("/home/PDKs/OA65_LIB/tsmcN65/../models/spectre/crn65gplus_2d5_lk_v1d0.scs" "tt_dio_25ud18")
;    '("/home/PDKs/OA65_LIB/tsmcN65/../models/spectre/crn65gplus_2d5_lk_v1d0.scs" "tt_25")
;    '("/home/PDKs/OA65_LIB/tsmcN65/../models/spectre/crn65gplus_2d5_lk_v1d0.scs" "tt_rfmos")
;    '("/home/PDKs/OA65_LIB/tsmcN65/../models/spectre/crn65gplus_2d5_lk_v1d0.scs" "tt_25ud18")
;    '("/home/PDKs/OA65_LIB/tsmcN65/../models/spectre/crn65gplus_2d5_lk_v1d0.scs" "tt_dio_na25od33")
;    '("/home/PDKs/OA65_LIB/tsmcN65/../models/spectre/crn65gplus_2d5_lk_v1d0.scs" "tt_rfjvar")
;    '("/home/PDKs/OA65_LIB/tsmcN65/../models/spectre/crn65gplus_2d5_lk_v1d0.scs" "tt_rfmos_25")
;    '("/home/PDKs/OA65_LIB/tsmcN65/../models/spectre/crn65gplus_2d5_lk_v1d0.scs" "tt_rtmom")
;    '("/home/PDKs/OA65_LIB/tsmcN65/../models/spectre/crn65gplus_2d5_lk_v1d0.scs" "tt_na25od33")
;    '("/home/PDKs/OA65_LIB/tsmcN65/../models/spectre/crn65gplus_2d5_lk_v1d0.scs" "tt_dio_na25")
;    '("/home/PDKs/OA65_LIB/tsmcN65/../models/spectre/crn65gplus_2d5_lk_v1d0.scs" "tt_rfres_rpo")
;    '("/home/PDKs/OA65_LIB/tsmcN65/../models/spectre/crn65gplus_2d5_lk_v1d0.scs" "tt_hvt")
;    '("/home/PDKs/OA65_LIB/tsmcN65/../models/spectre/crn65gplus_2d5_lk_v1d0.scs" "tt_rfind")
;    '("/home/PDKs/OA65_LIB/tsmcN65/../models/spectre/crn65gplus_2d5_lk_v1d0.scs" "tt_rfmvar_25")
;    '("/home/PDKs/OA65_LIB/tsmcN65/../models/spectre/crn65gplus_2d5_lk_v1d0.scs" "tt_na25")
;    '("/home/PDKs/OA65_LIB/tsmcN65/../models/spectre/crn65gplus_2d5_lk_v1d0.scs" "tt_lvt")
;)
analysis('sp ?ports list("/PORT0" "/PORT1")  ?start "0"  ?stop "60G"
		?step "1G"  )
desVar(	  "C" C_x	)	; C_x is specified from the input file (See top part)
desVar(	  "L" L_x	)	; L_x is specified from the input file (See top part)
envOption(
	'analysisOrder  list("sp")
)
temp( 27 )
run()

;;;;; Begin ;;;;;
printf("Begin   \n")
results()
selectResult( 'sp )
s11 = sp(1 1)
s12 = sp(1 2)
s21 = sp(2 1)
s22 = sp(2 2)
printf("Writing Files ...    \n")
OutputFile = outfile("/home/childish/OA65/Ocean_Scripts/tb_LC_Network_lsqnonlin/schematic_Fit_sp.txt" "w")
ocnPrint(?output OutputFile ?numberNotation 'none s11 s12 s21 s22)
close(OutputFile)
printf("End")
exit	; Terminate Spectre Operation
;;;;; End ;;;;;
